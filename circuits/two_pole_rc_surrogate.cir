* EEE6682 P3: OPTIONAL buffered 2-pole RC SURROGATE only
* NOT the CMOS TX/RX or the measured channel in Wong et al. JSSC 2004
* The Python behavioral model uses only time constant tau; R=50 is an
* arbitrarily chosen equivalent scale, and E1 is an IDEAL unity buffer.
* These AC netlist commands were NOT run here (ngspice unavailable).
* fc = 1.042524557 GHz; tau = 152.663 ps; |H(1.8GHz)| = 0.2511886
VIN in 0 DC 0 AC 1
R1 in n1 50
C1 n1 0 3.053260318p
E1 nb 0 n1 0 1
R2 nb out 50
C2 out 0 3.053260318p
.ac dec 80 10Meg 4Gig
.print ac vm(out) vp(out)
.end
